* =================================================================
* cascade.cir - two-cell EML cascade for depth-2 validation
*
* Computes  V_out = eml(eml(V_a, V_b), V_c)
*                 = exp( exp(V_a) - ln(V_b) ) - ln(V_c)
*
* Uses the op-amp cell subcircuit (cell_opamp_sub.cir).  Depth-2
* cascade is the minimum to exercise noise compounding:
*   cell 1: intermediate I = eml(V_a, V_b)
*   cell 2: output V_out = eml(I, V_c)
*
* Valid input envelope (so cell 1 output stays in cell 2's range):
*   V_a in [-1, 0.4]          (so exp(V_a) stays <= exp(0.4) ~ 1.5)
*   V_b in [exp(V_a)-1, 2.5]  (so I >= -1)
*   V_c in [ 0.1, 2 ]
* Safer: pick test points well inside this envelope.
* =================================================================

.include cell_opamp_sub.cir

Vcc vcc 0 15
Vee vee 0 -15

.param VA_DC=0.0 VB_DC=1.0 VC_DC=1.0

Va va 0 {VA_DC}
Vb vb 0 {VB_DC}
Vc vc 0 {VC_DC}

* Cell 1: intermediate = eml(va, vb)
Xcell1 va vb vint vcc vee eml_cell_opamp

* Cell 2: output = eml(vint, vc)
Xcell2 vint vc vout vcc vee eml_cell_opamp

.end
